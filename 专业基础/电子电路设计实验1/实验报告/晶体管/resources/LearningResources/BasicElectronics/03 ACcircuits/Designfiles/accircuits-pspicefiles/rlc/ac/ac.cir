** Profile: "RLC-ac"  [ h:\orcadœ‡πÿŒƒµµ\spb_data\cdssetup\orcad_capture\16.6.0\tclscripts\caplearningresources\work\supportfiles\basicelectronics\accircuits\designfiles\accircuits-pspicefiles\rlc\ac.sim ]

** Creating circuit file "ac.cir"
** WARNING: THIS AUTOMATICALLY GENERATED FILE MAY BE OVERWRITTEN BY SUBSEQUENT SIMULATIONS

*Libraries:
* Profile Libraries :
* Local Libraries :
* From [PSPICE NETLIST] section of d:\Cadence\SPB_16.5\tools\PSpice\PSpice.ini file:
.lib "nom.lib"

*Analysis directives:
.AC DEC 10001 1 50k
.PROBE V(alias(*)) I(alias(*)) W(alias(*)) D(alias(*)) NOISE(alias(*))
.INC "..\RLC.net"

.END
