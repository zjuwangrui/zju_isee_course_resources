** Profile: "fwd_floating-tran"  [ D:\Work\Modelling\SMPS_DEsign_Kit\Demo_feb_12\ac_dc_vrm-pspicefiles\fwd_floating\tran.sim ]

** Creating circuit file "tran.cir"
** WARNING: THIS AUTOMATICALLY GENERATED FILE MAY BE OVERWRITTEN BY SUBSEQUENT SIMULATIONS

*Libraries:
* Profile Libraries :
* Local Libraries :
.LIB "../../../ac_dc_vrm-pspicefiles/ac_dc_vrm.lib"
* From [PSPICE NETLIST] section of d:\Cadence\SPB_16.5\tools\PSpice\PSpice.ini file:
.lib "nom.lib"

*Analysis directives:
.TRAN  0 20us 0
.OPTIONS LIBRARY
.OPTIONS ABSTOL= 1.0u
.OPTIONS ITL4= 40
.PROBE V(alias(*)) I(alias(*))
.INC "..\fwd_floating.net"

.END
